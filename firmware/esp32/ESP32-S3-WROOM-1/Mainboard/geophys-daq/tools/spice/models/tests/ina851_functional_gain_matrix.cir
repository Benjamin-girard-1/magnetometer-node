INA851 functional model - gain matrix
.include ../INA851_functional.lib

VSP VSP 0 15
VSN 0 VSN 15
VOCM VOCM 0 0
VINN INN 0 0
VDIFF INP INN 1m

* G approximately 1, 2, 10 and 100.
RG1 RGP1 RGN1 1T
RG2 RGP2 RGN2 6k
RG10 RGP10 RGN10 666.6667
RG100 RGP100 RGN100 60.60606

XG1 INP INN RGP1 RGN1 VSP VSN O1P O1N VOCM A1 A2 A3 A4 VSP VSN INA851_FUNC
XG2 INP INN RGP2 RGN2 VSP VSN O2P O2N VOCM B1 B2 B3 B4 VSP VSN INA851_FUNC
XG10 INP INN RGP10 RGN10 VSP VSN O10P O10N VOCM C1 C2 C3 C4 VSP VSN INA851_FUNC
XG100 INP INN RGP100 RGN100 VSP VSN O100P O100N VOCM D1 D2 D3 D4 VSP VSN INA851_FUNC

R1 O1P O1N 10k
R2 O2P O2N 10k
R10 O10P O10N 10k
R100 O100P O100N 10k

.control
op
print v(o1p,o1n) v(o2p,o2n) v(o10p,o10n) v(o100p,o100n)
quit
.endc
.end
