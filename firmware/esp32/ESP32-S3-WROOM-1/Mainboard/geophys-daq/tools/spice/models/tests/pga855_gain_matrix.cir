PGA855 functional model - all eight gains
.include ../PGA855_functional.lib

VSP VSP 0 15
VSN 0 VSN 15
VLP VLP 0 15
VLN 0 VLN 15
VDG DGND 0 0
VOC VOCM 0 0
VINN INN 0 0
VDIFF INP INN 1m
VH HIGH 0 3.3
VL LOW 0 0

* A2:A0 = 000 through 111.
X0 LOW INP INN LOW LOW VSP VLP F0N O0P O0N F0P VOCM VLN VSN DGND PGA855_FUNC
X1 LOW INP INN HIGH LOW VSP VLP F1N O1P O1N F1P VOCM VLN VSN DGND PGA855_FUNC
X2 LOW INP INN LOW HIGH VSP VLP F2N O2P O2N F2P VOCM VLN VSN DGND PGA855_FUNC
X3 LOW INP INN HIGH HIGH VSP VLP F3N O3P O3N F3P VOCM VLN VSN DGND PGA855_FUNC
X4 HIGH INP INN LOW LOW VSP VLP F4N O4P O4N F4P VOCM VLN VSN DGND PGA855_FUNC
X5 HIGH INP INN HIGH LOW VSP VLP F5N O5P O5N F5P VOCM VLN VSN DGND PGA855_FUNC
X6 HIGH INP INN LOW HIGH VSP VLP F6N O6P O6N F6P VOCM VLN VSN DGND PGA855_FUNC
X7 HIGH INP INN HIGH HIGH VSP VLP F7N O7P O7N F7P VOCM VLN VSN DGND PGA855_FUNC

R0 O0P O0N 10k
R1 O1P O1N 10k
R2 O2P O2N 10k
R3 O3P O3N 10k
R4 O4P O4N 10k
R5 O5P O5N 10k
R6 O6P O6N 10k
R7 O7P O7N 10k

.control
op
print v(o0p,o0n) v(o1p,o1n) v(o2p,o2n) v(o3p,o3n)
print v(o4p,o4n) v(o5p,o5n) v(o6p,o6n) v(o7p,o7n)
quit
.endc
.end
