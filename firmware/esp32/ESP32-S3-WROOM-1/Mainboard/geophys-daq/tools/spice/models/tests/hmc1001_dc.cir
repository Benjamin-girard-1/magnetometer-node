HMC1001 functional model - sensitivity and offset
.include ../HMC1001_functional.lib

VBRIDGE VBP 0 5
VFIELD FIELD 0 1
XHMC VBP OUTP OUTN 0 FIELD HMC1001_SPICE
+ params: SENS=3.2m OFFSET=1m VCAL=5
RLOAD OUTP OUTN 1G

.control
op
print v(xhmc.xcore.delta) v(outp,outn) v(outp) v(outn)
quit
.endc
.end
