INA851 functional model - AC bandwidth test, G=2
.include ../INA851_functional.lib

VSP VSP 0 15
VSN 0 VSN 15
VOCM VOCM 0 0
VINN INN 0 0
VDIFF INP INN DC 0 AC 1
RG RGP RGN 6k
XU1 INP INN RGP RGN VSP VSN OUTP OUTN VOCM FDAIP FDAIN G02P G02N VSP VSN INA851_FUNC
RL OUTP OUTN 10k
CL OUTP OUTN 100p

.control
ac dec 100 10 100Meg
let voutdiff = v(outp)-v(outn)
let gain_db = db(voutdiff)
meas ac gain_dc find gain_db at=10
meas ac f3db when gain_db=gain_dc-3
print gain_dc f3db
quit
.endc
.end
